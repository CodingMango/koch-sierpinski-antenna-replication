# Ansys Electronics Desktop project, version 2025.2
materials:
  vacuum: permittivity=1
  FR4_paper: permittivity=4.7 dielectric_loss_tangent=0.0197

design KochSierp_replica (HFSS, HFSS Modal Network, model units mm)
variables:
  Sl = 60mm
  Sw = 40mm
  h = 0.8mm
  Fw = 1.8mm
  Fl = 18.5mm
  D1 = 5mm
  D2 = 13.88mm
  pad = 37.5mm
  Wp = 10mm
  Hp = 6mm
geometry:
  Substrate [FR4_paper] = box(corner=(-Sl/2, -Sw/2, -h), size=(Sl, Sw, h))
  Gnd = rectangle(corner=(-Sl/2, -Sw/2, -h), x_size=Sl, y_size=Sw)
  FEED_2, HOLES_3..HOLES_75, PATCH = imported_body(C:/temp/234F4184179286206111..x_t)
  PATCH.unite(FEED_2)
  PATCH.subtract(HOLES_10..HOLES_29, HOLES_3, HOLES_30..HOLES_39, HOLES_4, HOLES_40..HOLES_49, HOLES_5, HOLES_50..HOLES_59, HOLES_6, HOLES_60..HOLES_69, HOLES_7, HOLES_70..HOLES_75, HOLES_8, HOLES_9)
  Region [vacuum] = region(absolute_offset: +X=0mm, -X=pad, +Y=pad, -Y=pad, +Z=pad, -Z=pad)
  Port1 = rectangle(corner=(Sl/2, -Wp/2, -h), y_size=Wp, z_size=Hp)
boundaries and excitations:
  PE_GND: Perfect E Objects=Gnd
  PE_Patch: Perfect E Objects=PATCH
  Rad: Radiation Objects=Region
  1: Wave Port Objects=Port1 WavePortType=Default NumModes=1 Modes{Mode1{IntLine{(30, 0, -0.8) -> (30, 0, 0)} CharImp=Zpi RenormImp=50ohm}}
setups:
  Setup1: HfssDriven MultipleAdaptiveFreqsSetup{AdaptAt{Frequency=2.11GHz Delta=0.02} AdaptAt{Frequency=5.78GHz Delta=0.02} AdaptAt{Frequency=9.56GHz Delta=0.02}} MaximumPasses=15 MinimumPasses=1 MinimumConvergedPasses=1 PercentRefinement=30 BasisOrder=1 PortAccuracy=2 DrivenSolverType="Direct Solver"
    sweep Sweep: 1GHz to 12GHz step 0.01GHz; Type=Interpolating InterpTolerance=0.5 InterpMaxSolns=250 InterpUsePortImped=false PassivityErrorTolerance=0.0001
source amplitudes:
  1:1: 1W 0deg
reports:
  S Parameter Plot1: dB(S(1,1)), VSWR(1), re(Zo(1)), im(Zo(1)) vs Freq on Setup1 : Sweep
